* Schmitt trigger CMOS 6T - circuito esquina tt
* Sizing FINAL: MP_FB W=16.0 L=64.0 | MN_FB W=8.0 L=64.0
* (incluido por el testbench maestro schmitt_tb.spice via 'source')

.lib /home/zanz19/pdk/sky130A/libs.tech/ngspice/sky130.lib.spice tt

.param ttemp=27
.options temp={ttemp}

Vdd VDD 0 DC 1.8
Vin vin  0 PWL(
+ 0 0  50u 1.8  100u 0
+ 100.005u 1.8  101u 1.8  101.005u 0  102u 0
+ 102.005u 1.8  103u 1.8  103.005u 0  104u 0
+ 104.005u 1.8  105u 1.8  105.005u 0  106u 0
+ 106.005u 1.8  107u 1.8  107.005u 0  108u 0
+ 108.005u 1.8  109u 1.8  109.005u 0  110u 0
+ )

* --- PMOS (D G S B) ---
XMP_FB  nodo_p vout VDD    VDD sky130_fd_pr__pfet_01v8 L=64.0 W=16.0 nf=1 ad=4.64 as=4.64 pd=32.58 ps=32.58 nrd=0.018125 nrs=0.018125 sa=0 sb=0 sd=0 mult=1 m=1
XMP1    nodo_p vin  VDD    VDD sky130_fd_pr__pfet_01v8 L=0.15 W=2.0 nf=1 ad=0.58  as=0.58  pd=4.58 ps=4.58 nrd=0.145  nrs=0.145  sa=0 sb=0 sd=0 mult=1 m=1
XMP2    vout   vin  nodo_p VDD sky130_fd_pr__pfet_01v8 L=0.15 W=2.0 nf=1 ad=0.58  as=0.58  pd=4.58 ps=4.58 nrd=0.145  nrs=0.145  sa=0 sb=0 sd=0 mult=1 m=1

* --- NMOS (D G S B) ---
XMN1    vout   vin  nodo_n 0   sky130_fd_pr__nfet_01v8 L=0.15 W=1.0 nf=1 ad=0.29  as=0.29  pd=2.58 ps=2.58 nrd=0.29   nrs=0.29   sa=0 sb=0 sd=0 mult=1 m=1
XMN2    nodo_n vin  0      0   sky130_fd_pr__nfet_01v8 L=0.15 W=1.0 nf=1 ad=0.29  as=0.29  pd=2.58 ps=2.58 nrd=0.29   nrs=0.29   sa=0 sb=0 sd=0 mult=1 m=1
XMN_FB  nodo_n vout 0      0   sky130_fd_pr__nfet_01v8 L=64.0 W=8.0 nf=1 ad=2.32 as=2.32 pd=16.58 ps=16.58 nrd=0.03625 nrs=0.03625 sa=0 sb=0 sd=0 mult=1 m=1

.end
